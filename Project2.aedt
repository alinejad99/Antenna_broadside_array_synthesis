# Ansys Electronics Desktop project, version 2022.1
materials:
  copper: permeability=0.999991 conductivity=58000000
  vacuum: permittivity=1

design HFSSDesign2 (HFSS, DrivenModal, model units mm)
variables:
  f0 = 72MHz
  ld = c0/f0
  gap = (ld/20) meter
  d_max = 8.4meter
  I = 85.5ohm
geometry:
  Cylinder1 [copper] = cylinder(axis=Z, base_centre=(0mm, 0mm, gap/2), radius=ld/50, height=ld/2)
  Cylinder1_1 [copper] = Cylinder1.duplicate_mirror(point=(0mm, 0mm, 0mm), normal=(0mm, 0mm, 1mm))
  [Cylinder1, Cylinder1_1].move(-d_max/2, 0mm, 0mm)
  Cylinder1_2..Cylinder1_5 [copper] = Cylinder1.duplicate_along_line(step=(-d_max, 0mm, 0mm), total=5)
  Cylinder1_1_1..Cylinder1_1_4 [copper] = Cylinder1_1.duplicate_along_line(step=(-d_max, 0mm, 0mm), total=5)
  Cylinder1_6..Cylinder1_10 [copper] = Cylinder1.duplicate_along_line(step=(d_max, 0mm, 0mm), total=6)
  Cylinder1_1_5..Cylinder1_1_9 [copper] = Cylinder1_1.duplicate_along_line(step=(d_max, 0mm, 0mm), total=6)
  Cylinder1_2_1..Cylinder1_2_5 [copper] = Cylinder1_2.duplicate_along_line(step=(d_max, 0mm, 0mm), total=6)
  Cylinder1_3_1..Cylinder1_3_5 [copper] = Cylinder1_3.duplicate_along_line(step=(d_max, 0mm, 0mm), total=6)
  Cylinder1_4_1..Cylinder1_4_5 [copper] = Cylinder1_4.duplicate_along_line(step=(d_max, 0mm, 0mm), total=6)
  Cylinder1_5_1..Cylinder1_5_5 [copper] = Cylinder1_5.duplicate_along_line(step=(d_max, 0mm, 0mm), total=6)
  Cylinder1_1_1_1..Cylinder1_1_1_5 [copper] = Cylinder1_1_1.duplicate_along_line(step=(d_max, 0mm, 0mm), total=6)
  Cylinder1_1_2_1..Cylinder1_1_2_5 [copper] = Cylinder1_1_2.duplicate_along_line(step=(d_max, 0mm, 0mm), total=6)
  Cylinder1_1_3_1..Cylinder1_1_3_5 [copper] = Cylinder1_1_3.duplicate_along_line(step=(d_max, 0mm, 0mm), total=6)
  Cylinder1_1_4_1..Cylinder1_1_4_5 [copper] = Cylinder1_1_4.duplicate_along_line(step=(d_max, 0mm, 0mm), total=6)
  Region [vacuum] = region(percentage_offset=100 on all sides)
  Rectangle1 = rectangle(corner=(-d_max*4.5-ld/50, 0mm, -gap/2), z_size=gap, x_size=ld/25)
  Rectangle1_1..Rectangle1_9 = Rectangle1.duplicate_along_line(step=(d_max, 0mm, 0mm), total=10)
boundaries and excitations:
  Rad1: Radiation Objects=Region
  1: Lumped Port Objects=Rectangle1 Modes{Mode1{IntLine{(-37800, 0, -104.0946) -> (-37800, 0, 104.0946)} CharImp=Zpi RenormImp=I}} Impedance=50ohm
  2: Lumped Port Objects=Rectangle1_1 Modes{Mode1{IntLine{(-29400, 0, -104.0946) -> (-29400, 0, 104.0946)} CharImp=Zpi RenormImp=I}} Impedance=50ohm
  3: Lumped Port Objects=Rectangle1_2 Modes{Mode1{IntLine{(-21000, 0, -104.0946) -> (-21000, 0, 104.0946)} CharImp=Zpi RenormImp=I}} Impedance=50ohm
  4: Lumped Port Objects=Rectangle1_3 Modes{Mode1{IntLine{(-12600, 0, -104.0946) -> (-12600, 0, 104.0946)} CharImp=Zpi RenormImp=I}} Impedance=50ohm
  5: Lumped Port Objects=Rectangle1_4 Modes{Mode1{IntLine{(-4200, 0, -104.0946) -> (-4200, 0, 104.0946)} CharImp=Zpi RenormImp=I}} Impedance=50ohm
  6: Lumped Port Objects=Rectangle1_5 Modes{Mode1{IntLine{(4200, 0, -104.0946) -> (4200, 0, 104.0946)} CharImp=Zpi RenormImp=I}} Impedance=50ohm
  7: Lumped Port Objects=Rectangle1_6 Modes{Mode1{IntLine{(12600, 0, -104.0946) -> (12600, 0, 104.0946)} CharImp=Zpi RenormImp=I}} Impedance=50ohm
  8: Lumped Port Objects=Rectangle1_7 Modes{Mode1{IntLine{(21000, 0, -104.0946) -> (21000, 0, 104.0946)} CharImp=Zpi RenormImp=I}} Impedance=50ohm
  9: Lumped Port Objects=Rectangle1_8 Modes{Mode1{IntLine{(29400, 0, -104.0946) -> (29400, 0, 104.0946)} CharImp=Zpi RenormImp=I}} Impedance=50ohm
  10: Lumped Port Objects=Rectangle1_9 Modes{Mode1{IntLine{(37800, 0, -104.0946) -> (37800, 0, 104.0946)} CharImp=Zpi RenormImp=I}} Impedance=50ohm
setups:
  Setup1: HfssDriven Frequency=72MHz MaxDeltaS=0.02 MaximumPasses=6 MinimumPasses=6 MinimumConvergedPasses=3 PercentRefinement=30 BasisOrder=1 PortAccuracy=2 DrivenSolverType="Direct Solver"
source amplitudes:
  1:1, 10:1: 65.13W 0deg
  2:1, 9:1: 53.5W 0deg
  3:1, 8:1: 35.37W 0deg
  4:1, 7:1: 17.81W 0deg
  5:1, 6:1: 6.02W 0deg
radiation setups:
  Infinite Sphere1: Infinite Sphere Theta=0deg..180deg step 2deg Phi=-180deg..180deg step 2deg
reports:
  Gain Plot 1: dB(GainTotal) vs Theta on Setup1 : LastAdaptive, Infinite Sphere1 [Phi=0deg Freq=0.031GHz]
  Gain Plot 2: dB(GainTotal) vs Phi on Setup1 : LastAdaptive, Infinite Sphere1 [Theta=90deg Freq=0.031GHz]
  Gain Plot 3: dB(GainTotal) vs Phi, Theta on Setup1 : LastAdaptive, Infinite Sphere1 [Freq=0.031GHz]
  Gain Plot 4: dB(GainTotal) vs Theta on Setup1 : LastAdaptive, Infinite Sphere1 [Phi=0deg Freq=0.072GHz]
  Gain Plot 5: dB(GainTotal) vs Phi on Setup1 : LastAdaptive, Infinite Sphere1 [Theta=90deg Freq=0.072GHz]
  Gain Plot 6: dB(GainTotal) vs Phi, Theta on Setup1 : LastAdaptive, Infinite Sphere1 [Freq=0.072GHz]
